# Ansys Electronics Desktop project, version 2024.2
materials:
  vacuum: permittivity=1
  Rogers RT/duroid 5880 (tm): permittivity=2.2 dielectric_loss_tangent=0.0009
  copper: permeability=0.999991 conductivity=58000000

design Microstrip (HFSS, HFSS Terminal Network, model units mm)
options: open_region{BoundaryType=0 OpFreq=3GHz}
variables:
  sub_x = 50mm
  sub_y = 50mm
  sub_h = 1.575mm
  gnd_t = 18um
  strip_w = 3.95mm
geometry:
  Substract [Rogers RT/duroid 5880 (tm)] = box(corner=(-sub_x/2, -sub_y/2, 0mm), size=(sub_x, sub_y, -sub_h))
  RadiatingSurface [vacuum] = region(absolute_offset=33.333333mm on all sides)
  Ground [copper] = object_from(Substract.face(-z))
  Ground.thicken(gnd_t)
  Hybrid [copper] = box(corner=(-strip_w/2, -sub_y/2, 0mm), size=(strip_w, sub_y, gnd_t))
  port_1 [copper] = object_from(Hybrid.edge(at (0, -25, 0)))
  Substract_ObjectFromEdge1 = object_from(Substract.edge(at (25, -25, -0.7875)))
  port_1.sweep_along_path(Substract_ObjectFromEdge1)
  port_2 [copper] = object_from(Hybrid.edge(at (0, 25, 0)))
  Substract_ObjectFromEdge2 = object_from(Substract.edge(at (25, 25, -0.7875)))
  port_2.sweep_along_path(Substract_ObjectFromEdge2)
boundaries and excitations:
  AutoOpen1: Radiation Objects=RadiatingSurface
  Hybrid_T1: Terminal port=1 Edges=Hybrid.edge(at (0, -25, 0)) TerminalResistance=50ohm
  Hybrid_T2: Terminal port=2 Edges=Hybrid.edge(at (0, 25, 0)) TerminalResistance=50ohm
  1: Lumped Port Faces=port_1.face LumpedPortType=Terminal Impedance=50ohm
  2: Lumped Port Faces=port_2.face LumpedPortType=Terminal Impedance=50ohm
  reference conductors: Ground
mesh:
  MeshRegion1: Mesh Region Objects=Substract
setups:
  Auto1: HfssDriven MultipleAdaptiveFreqsSetup{AdaptAt{Frequency=1GHz Delta=0.01} AdaptAt{Frequency=2.5GHz Delta=0.01} AdaptAt{Frequency=5GHz Delta=0.01}} MaximumPasses=15 MinimumPasses=1 MinimumConvergedPasses=1 PercentRefinement=30 BasisOrder=1 PortAccuracy=2 DrivenSolverType="Direct Solver"
    sweep Sweep: 1GHz to 5GHz step 0.01GHz; Type=Interpolating InterpTolerance=0.5 InterpMaxSolns=250 PassivityErrorTolerance=0.0001
source amplitudes:
  1:1: 1V 0deg
  2:1: 0V 0deg
radiation setups:
  3D: Infinite Sphere Theta=0deg..180deg step 2deg Phi=-180deg..180deg step 2deg
  Elevation: Infinite Sphere Theta=-180deg..180deg step 1deg Phi=0deg..90deg step 90deg
  Azimuth: Infinite Sphere Theta=90deg..90deg step 0deg Phi=-180deg..180deg step 1deg

design Hybrid_90 (HFSS, HFSS Terminal Network, model units mm)
options: open_region{BoundaryType=0 OpFreq=2.75GHz}
variables:
  sub_x = 50mm
  sub_y = 50mm
  sub_h = 1.575mm
  gnd_t = 18um
  strip_w = 3.95mm
  hyb_x = 30mm
  hyb_y = 30mm
  hyb_w2 = 9.8mm
  hyb_w1 = 16.2mm
  cham_r = 1mm
  w50 = 4.8mm
geometry:
  Substract [Rogers RT/duroid 5880 (tm)] = box(corner=(-sub_x/2, -sub_y/2, 0mm), size=(sub_x, sub_y, -sub_h))
  RadiatingSurface [vacuum] = region(absolute_offset=36.363636mm on all sides)
  Ground [copper] = object_from(Substract.face(-z))
  Ground.thicken(gnd_t)
  Hybrid [copper] = box(corner=(-hyb_x/2, -hyb_y/2, 0mm), size=(hyb_x, hyb_y, gnd_t))
  Hybrid1 = box(corner=(-(hyb_x-hyb_w1)/2, -(hyb_y-hyb_w2)/2, 0mm), size=(hyb_x-hyb_w1, hyb_y-hyb_w2, gnd_t))
  Hybrid.subtract(Hybrid1)
  Hybrid.chamfer(Edges=Hybrid.edge(at (15, -15, 0.009)) LeftDistance=cham_r RightDistance=cham_r ChamferType=Symmetric ChamferAdditionalGeometryInfo{ChamferEdgeGeometryInfo{ChamferEdgeID=250 ChamferEdgeSense ChamferEdgeStart{X=15mm Y=-15mm Z=0mm} ChamferEdgeEnd{X=15mm Y=-15mm Z=0.018mm} ChamferEdgeMid{X=15mm Y=-15mm Z=0.009mm} ChamferEdgeMidTangent(0, 0, 1)}})
  Hybrid.chamfer(Edges=Hybrid.edge(at (-15, -15, 0.009)) LeftDistance=cham_r RightDistance=cham_r ChamferType=Symmetric ChamferAdditionalGeometryInfo{ChamferEdgeGeometryInfo{ChamferEdgeID=249 ChamferEdgeSense ChamferEdgeStart{X=-15mm Y=-15mm Z=0mm} ChamferEdgeEnd{X=-15mm Y=-15mm Z=0.018mm} ChamferEdgeMid{X=-15mm Y=-15mm Z=0.009mm} ChamferEdgeMidTangent(0, 0, 1)}})
  Hybrid.chamfer(Edges=Hybrid.edge(at (-15, 15, 0.009)) LeftDistance=cham_r RightDistance=cham_r ChamferType=Symmetric ChamferAdditionalGeometryInfo{ChamferEdgeGeometryInfo{ChamferEdgeID=251 ChamferEdgeSense ChamferEdgeStart{X=-15mm Y=15mm Z=0mm} ChamferEdgeEnd{X=-15mm Y=15mm Z=0.018mm} ChamferEdgeMid{X=-15mm Y=15mm Z=0.009mm} ChamferEdgeMidTangent(0, 0, 1)}})
  Hybrid.chamfer(Edges=Hybrid.edge(at (15, 15, 0.009)) LeftDistance=cham_r RightDistance=cham_r ChamferType=Symmetric ChamferAdditionalGeometryInfo{ChamferEdgeGeometryInfo{ChamferEdgeID=252 ChamferEdgeSense ChamferEdgeStart{X=15mm Y=15mm Z=0mm} ChamferEdgeEnd{X=15mm Y=15mm Z=0.018mm} ChamferEdgeMid{X=15mm Y=15mm Z=0.009mm} ChamferEdgeMidTangent(0, 0, 1)}})
  perna1 [copper] = box(corner=(-8mm, -15mm, 0mm), size=(w50, -10mm, 18um))
  perna1.move(-1mm, 0mm, -0.018mm)
  perna4 [copper] = perna1.duplicate_mirror(point=(0mm, 0mm, 0mm), normal=(1mm, 0mm, 0mm))
  perna3 [copper] = perna4.duplicate_mirror(point=(0mm, 0mm, 0mm), normal=(0mm, 1mm, 0mm))
  perna2 [copper] = perna1.duplicate_mirror(point=(0mm, 0mm, 0mm), normal=(0mm, 1mm, 0mm))
  porta1 [copper] = object_from(perna1.edge(at (-8, -25, -0.018)))
  Substract_ObjectFromEdge1 = object_from(Substract.edge(at (-25, -25, -0.7875)))
  porta1.sweep_along_path(Substract_ObjectFromEdge1)
  porta4 [copper] = porta1.duplicate_mirror(point=(0mm, 0mm, 0mm), normal=(1mm, 0mm, 0mm))
  porta2 [copper] = porta1.duplicate_mirror(point=(0mm, 0mm, 0mm), normal=(0mm, 1mm, 0mm))
  porta3 [copper] = porta4.duplicate_mirror(point=(0mm, 0mm, 0mm), normal=(0mm, 1mm, 0mm))
  [porta1, perna1, perna2, porta2].move(-4mm, 0mm, 0mm)
  [porta4, perna4, perna3, porta3].move(4mm, 0mm, 0mm)
boundaries and excitations:
  AutoOpen1: Radiation Objects=RadiatingSurface
  perna1_T1: Terminal port=1 Faces=perna1.face(-y) TerminalResistance=50ohm
  perna2_T1: Terminal port=2 Faces=perna2.face(at (-10.6, 25, -0.009)) TerminalResistance=50ohm
  perna3_T1: Terminal port=3 Faces=perna3.face(at (10.6, 25, -0.009)) TerminalResistance=50ohm
  perna4_T1: Terminal port=4 Faces=perna4.face(at (10.6, -25, -0.009)) TerminalResistance=50ohm
  1: Lumped Port Faces=porta1.face(at (-10.6, -25, -0.7875)) LumpedPortType=Terminal Impedance=50ohm
  2: Lumped Port Faces=porta2.face LumpedPortType=Terminal Impedance=50ohm
  3: Lumped Port Faces=porta3.face LumpedPortType=Terminal Impedance=50ohm
  4: Lumped Port Faces=porta4.face(at (10.6, -25, -0.7875)) LumpedPortType=Terminal Impedance=50ohm
  reference conductors: Ground
mesh:
  MeshRegion1: Mesh Region Objects=Substract
  MeshRegion2: Mesh Region Objects=Hybrid
setups:
  Auto1: HfssDriven MultipleAdaptiveFreqsSetup{AdaptAt{Frequency=0.5GHz Delta=0.02} AdaptAt{Frequency=2.5GHz Delta=0.02} AdaptAt{Frequency=5GHz Delta=0.02}} MaximumPasses=15 MinimumPasses=1 MinimumConvergedPasses=1 PercentRefinement=30 BasisOrder=1 PortAccuracy=2 DrivenSolverType="Direct Solver"
    sweep Sweep: 1GHz to 5GHz step 0.01GHz; Type=Interpolating InterpTolerance=0.5 InterpMaxSolns=250 PassivityErrorTolerance=0.0001
source amplitudes:
  1:1: 1V 0deg
  2:1, 3:1, 4:1: 0V 0deg
radiation setups:
  3D: Infinite Sphere Theta=0deg..180deg step 2deg Phi=-180deg..180deg step 2deg
  Elevation: Infinite Sphere Theta=-180deg..180deg step 1deg Phi=0deg..90deg step 90deg
  Azimuth: Infinite Sphere Theta=90deg..90deg step 0deg Phi=-180deg..180deg step 1deg
reports:
  Terminal S Parameter Plot 1: dB(St(perna1_T1,perna1_T1)), dB(St(perna2_T1,perna1_T1)), dB(St(perna4_T1,perna1_T1)), dB(St(perna3_T1,perna1_T1)), dB(St(perna3_T1,perna2_T1)) vs Freq on Auto1 : Sweep
